| IBIS file stm32h723_730_733_lqfp144.ibs
[IBIS ver] 4.2
[File name] stm32h723_730_733_lqfp144.ibs
[File Rev] rev2.1
[Date]  06-03-2024
[Source] Data Created at STMicroelectronics
[Notes]  File originated from ELDO simulations.
[Disclaimer]  This information is for modeling purpose only and is
   not guaranteed. The information is subject to change without
   notice.
[Copyright] Copyright 2024 STMicroelectronics Inc.
|   Component stm32h723_730_733_lqfp144
[Component] stm32h723_730_733_lqfp144
[Manufacturer] STMicroelectronics
[Package]
| variable   typ   min   max
R_pkg  0 0 0
L_pkg  0 0 0
C_pkg  0 0 0
[Pin]   signal_name   model_name   R_pin   L_pin   C_pin   | Comment
1 PE2 io8_hslv_ft 187.6E-3 9.4E-9 267.9E-15
2 PE3 io8_hslv_ft 182.4E-3 9.1E-9 243.8E-15
3 PE4 io8_hslv_ft 177.6E-3 8.7E-9 221.3E-15
4 PE5 io8_hslv_ft 173.1E-3 8.4E-9 200.2E-15
5 PE6 io8_hslv_ft 168.9E-3 8.1E-9 180.5E-15
6 VBAT power 165.0E-3 7.8E-9 162.3E-15
7 PC13 io8_ft 161.5E-3 7.6E-9 145.6E-15
8 PC14-OSC32_IN io8_ft 158.2E-3 7.4E-9 130.3E-15
9 PC15-OSC32_OUT io8_ft 155.2E-3 7.2E-9 116.4E-15
10 PF0 io8_hslv_i2c_ft 152.6E-3 7.0E-9 104.1E-15
11 PF1 io8_hslv_i2c_ft 150.3E-3 6.8E-9 93.2E-15
12 PF2 io8_hslv_ft 148.2E-3 6.7E-9 83.7E-15
13 PF3 io8_hslv_ft 146.5E-3 6.5E-9 75.7E-15
14 PF4 io8_hslv_ft 145.1E-3 6.4E-9 69.1E-15
15 PF5 io8_hslv_ft 144.1E-3 6.4E-9 64.0E-15
16 VSS gnd 143.3E-3 6.3E-9 60.4E-15
17 VDD power 142.8E-3 6.3E-9 58.2E-15
18 PF6 io8_hslv_ft 142.7E-3 6.3E-9 57.5E-15
19 PF7 io8_hslv_ft 142.7E-3 6.3E-9 57.5E-15
20 PF8 io8_hslv_ft 142.8E-3 6.3E-9 58.2E-15
21 PF9 io8_hslv_ft 143.3E-3 6.3E-9 60.4E-15
22 PF10 io8_hslv_ft 144.1E-3 6.4E-9 64.0E-15
23 PH0-OSC_IN io8_ft 145.1E-3 6.4E-9 69.1E-15
24 PH1-OSC_OUT io8_ft 146.5E-3 6.5E-9 75.7E-15
25 NRST ioreset_ft 148.2E-3 6.7E-9 83.7E-15
26 PC0 io8_hslv_ft 150.3E-3 6.8E-9 93.2E-15
27 PC1 io8_hslv_ft 152.6E-3 7.0E-9 104.1E-15
28 PC2_C nc 155.2E-3 7.2E-9 116.4E-15
29 PC3_C nc 158.2E-3 7.4E-9 130.3E-15
30 VDD power 161.5E-3 7.6E-9 145.6E-15
31 VSSA gnd 165.0E-3 7.8E-9 162.3E-15
32 VREFP power 168.9E-3 8.1E-9 180.5E-15
33 VDDA power 173.1E-3 8.4E-9 200.2E-15
34 PA0 io8_hslv_ft 177.6E-3 8.7E-9 221.3E-15
35 PA1 io8_hslv_ft 182.4E-3 9.1E-9 243.8E-15
36 PA2 io8_hslv_ft 187.6E-3 9.4E-9 267.9E-15
37 PA3 io8_hslv_ft 187.6E-3 9.4E-9 267.9E-15
38 VSS gnd 182.4E-3 9.1E-9 243.8E-15
39 VDD power 177.6E-3 8.7E-9 221.3E-15
40 PA4 io8_hslv_ft 173.1E-3 8.4E-9 200.2E-15
41 PA5 io8_hslv_ft 168.9E-3 8.1E-9 180.5E-15
42 PA6 io8_hslv_ft 165.0E-3 7.8E-9 162.3E-15
43 PA7 io8_hslv_ft 161.5E-3 7.6E-9 145.6E-15
44 PC4 io8_hslv_ft 158.2E-3 7.4E-9 130.3E-15
45 PC5 io8_hslv_ft 155.2E-3 7.2E-9 116.4E-15
46 PB0 io8_hslv_ft 152.6E-3 7.0E-9 104.1E-15
47 PB1 io8_hslv_ft 150.3E-3 6.8E-9 93.2E-15
48 PB2 io8_hslv_ft 148.2E-3 6.7E-9 83.7E-15
49 PF11 io8_hslv_ft 146.5E-3 6.5E-9 75.7E-15
50 PF12 io8_hslv_ft 145.1E-3 6.4E-9 69.1E-15
51 VSS gnd 144.1E-3 6.4E-9 64.0E-15
52 VDD power 143.3E-3 6.3E-9 60.4E-15
53 PF13 io8_hslv_ft 142.8E-3 6.3E-9 58.2E-15
54 PF14 io8_hslv_i2c_ft 142.7E-3 6.3E-9 57.5E-15
55 PF15 io8_hslv_i2c_ft 142.7E-3 6.3E-9 57.5E-15
56 PG0 io8_hslv_ft 142.8E-3 6.3E-9 58.2E-15
57 PG1 io8_hslv_ft 143.3E-3 6.3E-9 60.4E-15
58 PE7 io8_hslv_ft 144.1E-3 6.4E-9 64.0E-15
59 PE8 io8_hslv_ft 145.1E-3 6.4E-9 69.1E-15
60 PE9 io8_hslv_ft 146.5E-3 6.5E-9 75.7E-15
61 VSS gnd 148.2E-3 6.7E-9 83.7E-15
62 VDD power 150.3E-3 6.8E-9 93.2E-15
63 PE10 io8_hslv_ft 152.6E-3 7.0E-9 104.1E-15
64 PE11 io8_hslv_ft 155.2E-3 7.2E-9 116.4E-15
65 PE12 io8_hslv_ft 158.2E-3 7.4E-9 130.3E-15
66 PE13 io8_hslv_ft 161.5E-3 7.6E-9 145.6E-15
67 PE14 io8_hslv_ft 165.0E-3 7.8E-9 162.3E-15
68 PE15 io8_hslv_ft 168.9E-3 8.1E-9 180.5E-15
69 PB10 io8_hslv_i2c_ft 173.1E-3 8.4E-9 200.2E-15
70 PB11 io8_i2c_ft 177.6E-3 8.7E-9 221.3E-15
71 VCAP power 182.4E-3 9.1E-9 243.8E-15
72 VDD power 187.6E-3 9.4E-9 267.9E-15
73 PB12 io8_hslv_ft 187.6E-3 9.4E-9 267.9E-15
74 PB13 io8_hslv_ft 182.4E-3 9.1E-9 243.8E-15
75 PB14 io8_hslv_ft 177.6E-3 8.7E-9 221.3E-15
76 PB15 io8_hslv_ft 173.1E-3 8.4E-9 200.2E-15
77 PD8 io8_hslv_ft 168.9E-3 8.1E-9 180.5E-15
78 PD9 io8_hslv_ft 165.0E-3 7.8E-9 162.3E-15
79 PD10 io8_hslv_ft 161.5E-3 7.6E-9 145.6E-15
80 PD11 io8_hslv_ft 158.2E-3 7.4E-9 130.3E-15
81 PD12 io8_hslv_i2c_ft 155.2E-3 7.2E-9 116.4E-15
82 PD13 io8_hslv_i2c_ft 152.6E-3 7.0E-9 104.1E-15
83 VSS gnd 150.3E-3 6.8E-9 93.2E-15
84 VDD power 148.2E-3 6.7E-9 83.7E-15
85 PD14 io8_hslv_ft 146.5E-3 6.5E-9 75.7E-15
86 PD15 io8_hslv_ft 145.1E-3 6.4E-9 69.1E-15
87 PG2 io8_hslv_ft 144.1E-3 6.4E-9 64.0E-15
88 PG3 io8_hslv_ft 143.3E-3 6.3E-9 60.4E-15
89 PG4 io8_hslv_ft 142.8E-3 6.3E-9 58.2E-15
90 PG5 io8_hslv_ft 142.7E-3 6.3E-9 57.5E-15
91 PG6 io8_hslv_ft 142.7E-3 6.3E-9 57.5E-15
92 PG7 io8_hslv_ft 142.8E-3 6.3E-9 58.2E-15
93 PG8 io8_hslv_ft 143.3E-3 6.3E-9 60.4E-15
94 VSS gnd 144.1E-3 6.4E-9 64.0E-15
95 VDD33_USB power 145.1E-3 6.4E-9 69.1E-15
96 PC6 io8_hslv_swp_ft 146.5E-3 6.5E-9 75.7E-15
97 PC7 io8_hslv_ft 148.2E-3 6.7E-9 83.7E-15
98 PC8 io8_hslv_ft 150.3E-3 6.8E-9 93.2E-15
99 PC9 io8_hslv_i2c_ft 152.6E-3 7.0E-9 104.1E-15
100 PA8 io8_hslv_i2c_ft 155.2E-3 7.2E-9 116.4E-15
101 PA9 io8usb_vbus_otg20_ft 158.2E-3 7.4E-9 130.3E-15
102 PA10 io8usb_id_otg20_ft 161.5E-3 7.6E-9 145.6E-15
103 PA11 io8usb_lsfs_bcd_otg20_ft 165.0E-3 7.8E-9 162.3E-15
104 PA12 io8usb_lsfs_bcd_otg20_ft 168.9E-3 8.1E-9 180.5E-15
105 PA13 io8_ft 173.1E-3 8.4E-9 200.2E-15
106 VCAP power 177.6E-3 8.7E-9 221.3E-15
107 VSS gnd 182.4E-3 9.1E-9 243.8E-15
108 VDD power 187.6E-3 9.4E-9 267.9E-15
109 PA14 io8_ft 187.6E-3 9.4E-9 267.9E-15
110 PA15 io8_ft 182.4E-3 9.1E-9 243.8E-15
111 PC10 io8_hslv_i2c_ft 177.6E-3 8.7E-9 221.3E-15
112 PC11 io8_hslv_i2c_ft 173.1E-3 8.4E-9 200.2E-15
113 PC12 io8_hslv_ft 168.9E-3 8.1E-9 180.5E-15
114 PD0 io8_hslv_ft 165.0E-3 7.8E-9 162.3E-15
115 PD1 io8_hslv_ft 161.5E-3 7.6E-9 145.6E-15
116 PD2 io8_hslv_ft 158.2E-3 7.4E-9 130.3E-15
117 PD3 io8_hslv_ft 155.2E-3 7.2E-9 116.4E-15
118 PD4 io8_hslv_ft 152.6E-3 7.0E-9 104.1E-15
119 PD5 io8_hslv_ft 150.3E-3 6.8E-9 93.2E-15
120 VSS gnd 148.2E-3 6.7E-9 83.7E-15
121 VDD power 146.5E-3 6.5E-9 75.7E-15
122 PD6 io8_hslv_ft 145.1E-3 6.4E-9 69.1E-15
123 PD7 io8_hslv_ft 144.1E-3 6.4E-9 64.0E-15
124 PG9 io8_hslv_ft 143.3E-3 6.3E-9 60.4E-15
125 PG10 io8_hslv_ft 142.8E-3 6.3E-9 58.2E-15
126 PG11 io8_hslv_ft 142.7E-3 6.3E-9 57.5E-15
127 PG12 io8_hslv_ft 142.7E-3 6.3E-9 57.5E-15
128 PG13 io8_hslv_ft 142.8E-3 6.3E-9 58.2E-15
129 PG14 io8_hslv_ft 143.3E-3 6.3E-9 60.4E-15
130 VSS gnd 144.1E-3 6.4E-9 64.0E-15
131 VDD power 145.1E-3 6.4E-9 69.1E-15
132 PG15 io8_hslv_ft 146.5E-3 6.5E-9 75.7E-15
133 PB3 io8_hslv_ft 148.2E-3 6.7E-9 83.7E-15
134 PB4 io8_hslv_ft 150.3E-3 6.8E-9 93.2E-15
135 PB5 io8_hslv_ft 152.6E-3 7.0E-9 104.1E-15
136 PB6 io8_hslv_i2c_ft 155.2E-3 7.2E-9 116.4E-15
137 PB7 io8_i2c_ft 158.2E-3 7.4E-9 130.3E-15
138 BOOT0 vpp_test_hv 161.5E-3 7.6E-9 145.6E-15
139 PB8 io8_hslv_i2c_ft 165.0E-3 7.8E-9 162.3E-15
140 PB9 io8_hslv_i2c_ft 168.9E-3 8.1E-9 180.5E-15
141 PE0 io8_hslv_ft 173.1E-3 8.4E-9 200.2E-15
142 PE1 io8_hslv_ft 177.6E-3 8.7E-9 221.3E-15
143 PDR_ON nc 182.4E-3 9.1E-9 243.8E-15
144 VDD power 187.6E-3 9.4E-9 267.9E-15
[Model Selector] io8_ft
io8_ft_hs_1v2  "General purpose IO. 5V tolerant. 1.2V range. High speed."
io8_ft_hs_1v8  "General purpose IO. 5V tolerant. 1.8V range. High speed."
io8_ft_hs_3v3  "General purpose IO. 5V tolerant. 3.3V range. High speed."
io8_ft_fs_1v2  "General purpose IO. 5V tolerant. 1.2V range. Fast speed."
io8_ft_fs_1v8  "General purpose IO. 5V tolerant. 1.8V range. Fast speed."
io8_ft_fs_3v3  "General purpose IO. 5V tolerant. 3.3V range. Fast speed."
io8_ft_ms_1v2  "General purpose IO. 5V tolerant. 1.2V range. Medium speed."
io8_ft_ms_1v8  "General purpose IO. 5V tolerant. 1.8V range. Medium speed."
io8_ft_ms_3v3  "General purpose IO. 5V tolerant. 3.3V range. Medium speed."
io8_ft_ls_1v2  "General purpose IO. 5V tolerant. 1.2V range. Low speed."
io8_ft_ls_1v8  "General purpose IO. 5V tolerant. 1.8V range. Low speed."
io8_ft_ls_3v3  "General purpose IO. 5V tolerant. 3.3V range. Low speed."
[Model Selector] io8_hslv_ft
io8_ft_hs_1v2  "General purpose IO. 5V tolerant. 1.2V range. High speed."
io8_ft_hs_1v8  "General purpose IO. 5V tolerant. 1.8V range. High speed."
io8_ft_hs_3v3  "General purpose IO. 5V tolerant. 3.3V range. High speed."
io8_ft_fs_1v2  "General purpose IO. 5V tolerant. 1.2V range. Fast speed."
io8_ft_fs_1v8  "General purpose IO. 5V tolerant. 1.8V range. Fast speed."
io8_ft_fs_3v3  "General purpose IO. 5V tolerant. 3.3V range. Fast speed."
io8_ft_ms_1v2  "General purpose IO. 5V tolerant. 1.2V range. Medium speed."
io8_ft_ms_1v8  "General purpose IO. 5V tolerant. 1.8V range. Medium speed."
io8_ft_ms_3v3  "General purpose IO. 5V tolerant. 3.3V range. Medium speed."
io8_ft_ls_1v2  "General purpose IO. 5V tolerant. 1.2V range. Low speed."
io8_ft_ls_1v8  "General purpose IO. 5V tolerant. 1.8V range. Low speed."
io8_ft_ls_3v3  "General purpose IO. 5V tolerant. 3.3V range. Low speed."
io8_hslv_ft_hs_1v2  "General purpose IO with low voltage optimization. 5V tolerant. 1.2V range. High speed."
io8_hslv_ft_hs_1v8  "General purpose IO with low voltage optimization. 5V tolerant. 1.8V range. High speed."
io8_hslv_ft_hs_2v5  "General purpose IO with low voltage optimization. 5V tolerant. 2.5V range. High speed."
io8_hslv_ft_fs_1v2  "General purpose IO with low voltage optimization. 5V tolerant. 1.2V range. Fast speed."
io8_hslv_ft_fs_1v8  "General purpose IO with low voltage optimization. 5V tolerant. 1.8V range. Fast speed."
io8_hslv_ft_fs_2v5  "General purpose IO with low voltage optimization. 5V tolerant. 2.5V range. Fast speed."
io8_hslv_ft_ms_1v2  "General purpose IO with low voltage optimization. 5V tolerant. 1.2V range. Medium speed."
io8_hslv_ft_ms_1v8  "General purpose IO with low voltage optimization. 5V tolerant. 1.8V range. Medium speed."
io8_hslv_ft_ms_2v5  "General purpose IO with low voltage optimization. 5V tolerant. 2.5V range. Medium speed."
io8_hslv_ft_ls_1v2  "General purpose IO with low voltage optimization. 5V tolerant. 1.2V range. Low speed."
io8_hslv_ft_ls_1v8  "General purpose IO with low voltage optimization. 5V tolerant. 1.8V range. Low speed."
io8_hslv_ft_ls_2v5  "General purpose IO with low voltage optimization. 5V tolerant. 2.5V range. Low speed."
[Model Selector] io8_hslv_i2c_ft
io8_ft_hs_1v2  "General purpose IO. 5V tolerant. 1.2V range. High speed."
io8_ft_hs_1v8  "General purpose IO. 5V tolerant. 1.8V range. High speed."
io8_ft_hs_3v3  "General purpose IO. 5V tolerant. 3.3V range. High speed."
io8_ft_fs_1v2  "General purpose IO. 5V tolerant. 1.2V range. Fast speed."
io8_ft_fs_1v8  "General purpose IO. 5V tolerant. 1.8V range. Fast speed."
io8_ft_fs_3v3  "General purpose IO. 5V tolerant. 3.3V range. Fast speed."
io8_ft_ms_1v2  "General purpose IO. 5V tolerant. 1.2V range. Medium speed."
io8_ft_ms_1v8  "General purpose IO. 5V tolerant. 1.8V range. Medium speed."
io8_ft_ms_3v3  "General purpose IO. 5V tolerant. 3.3V range. Medium speed."
io8_ft_ls_1v2  "General purpose IO. 5V tolerant. 1.2V range. Low speed."
io8_ft_ls_1v8  "General purpose IO. 5V tolerant. 1.8V range. Low speed."
io8_ft_ls_3v3  "General purpose IO. 5V tolerant. 3.3V range. Low speed."
io8_hslv_ft_hs_1v2  "General purpose IO with low voltage optimization. 5V tolerant. 1.2V range. High speed."
io8_hslv_ft_hs_1v8  "General purpose IO with low voltage optimization. 5V tolerant. 1.8V range. High speed."
io8_hslv_ft_hs_2v5  "General purpose IO with low voltage optimization. 5V tolerant. 2.5V range. High speed."
io8_hslv_ft_fs_1v2  "General purpose IO with low voltage optimization. 5V tolerant. 1.2V range. Fast speed."
io8_hslv_ft_fs_1v8  "General purpose IO with low voltage optimization. 5V tolerant. 1.8V range. Fast speed."
io8_hslv_ft_fs_2v5  "General purpose IO with low voltage optimization. 5V tolerant. 2.5V range. Fast speed."
io8_hslv_ft_ms_1v2  "General purpose IO with low voltage optimization. 5V tolerant. 1.2V range. Medium speed."
io8_hslv_ft_ms_1v8  "General purpose IO with low voltage optimization. 5V tolerant. 1.8V range. Medium speed."
io8_hslv_ft_ms_2v5  "General purpose IO with low voltage optimization. 5V tolerant. 2.5V range. Medium speed."
io8_hslv_ft_ls_1v2  "General purpose IO with low voltage optimization. 5V tolerant. 1.2V range. Low speed."
io8_hslv_ft_ls_1v8  "General purpose IO with low voltage optimization. 5V tolerant. 1.8V range. Low speed."
io8_hslv_ft_ls_2v5  "General purpose IO with low voltage optimization. 5V tolerant. 2.5V range. Low speed."
io8_i2c_ft_1v2  "General purpose IO with I2C functionality. 5V tolerant. 1.2V range"
io8_i2c_ft_1v8  "General purpose IO with I2C functionality. 5V tolerant. 1.8V range"
io8_i2c_ft_3v3  "General purpose IO with I2C functionality. 5V tolerant. 3.3V range"
[Model Selector] io8_hslv_swp_ft
io8_ft_hs_1v2  "General purpose IO. 5V tolerant. 1.2V range. High speed."
io8_ft_hs_1v8  "General purpose IO. 5V tolerant. 1.8V range. High speed."
io8_ft_hs_3v3  "General purpose IO. 5V tolerant. 3.3V range. High speed."
io8_ft_fs_1v2  "General purpose IO. 5V tolerant. 1.2V range. Fast speed."
io8_ft_fs_1v8  "General purpose IO. 5V tolerant. 1.8V range. Fast speed."
io8_ft_fs_3v3  "General purpose IO. 5V tolerant. 3.3V range. Fast speed."
io8_ft_ms_1v2  "General purpose IO. 5V tolerant. 1.2V range. Medium speed."
io8_ft_ms_1v8  "General purpose IO. 5V tolerant. 1.8V range. Medium speed."
io8_ft_ms_3v3  "General purpose IO. 5V tolerant. 3.3V range. Medium speed."
io8_ft_ls_1v2  "General purpose IO. 5V tolerant. 1.2V range. Low speed."
io8_ft_ls_1v8  "General purpose IO. 5V tolerant. 1.8V range. Low speed."
io8_ft_ls_3v3  "General purpose IO. 5V tolerant. 3.3V range. Low speed."
io8_hslv_ft_hs_1v2  "General purpose IO with low voltage optimization. 5V tolerant. 1.2V range. High speed."
io8_hslv_ft_hs_1v8  "General purpose IO with low voltage optimization. 5V tolerant. 1.8V range. High speed."
io8_hslv_ft_hs_2v5  "General purpose IO with low voltage optimization. 5V tolerant. 2.5V range. High speed."
io8_hslv_ft_fs_1v2  "General purpose IO with low voltage optimization. 5V tolerant. 1.2V range. Fast speed."
io8_hslv_ft_fs_1v8  "General purpose IO with low voltage optimization. 5V tolerant. 1.8V range. Fast speed."
io8_hslv_ft_fs_2v5  "General purpose IO with low voltage optimization. 5V tolerant. 2.5V range. Fast speed."
io8_hslv_ft_ms_1v2  "General purpose IO with low voltage optimization. 5V tolerant. 1.2V range. Medium speed."
io8_hslv_ft_ms_1v8  "General purpose IO with low voltage optimization. 5V tolerant. 1.8V range. Medium speed."
io8_hslv_ft_ms_2v5  "General purpose IO with low voltage optimization. 5V tolerant. 2.5V range. Medium speed."
io8_hslv_ft_ls_1v2  "General purpose IO with low voltage optimization. 5V tolerant. 1.2V range. Low speed."
io8_hslv_ft_ls_1v8  "General purpose IO with low voltage optimization. 5V tolerant. 1.8V range. Low speed."
io8_hslv_ft_ls_2v5  "General purpose IO with low voltage optimization. 5V tolerant. 2.5V range. Low speed."
io8_hslv_swpc_ft  "GP IO with low voltage opt. and SWP C functionality. 5V tolerant. 1.8V range"
io8_hslv_swpb_ft  "GP IO with low voltage opt. and SWP B functionality. 5V tolerant. 3.3V range"
[Model Selector] io8_i2c_ft
io8_ft_hs_1v2  "General purpose IO. 5V tolerant. 1.2V range. High speed."
io8_ft_hs_1v8  "General purpose IO. 5V tolerant. 1.8V range. High speed."
io8_ft_hs_3v3  "General purpose IO. 5V tolerant. 3.3V range. High speed."
io8_ft_fs_1v2  "General purpose IO. 5V tolerant. 1.2V range. Fast speed."
io8_ft_fs_1v8  "General purpose IO. 5V tolerant. 1.8V range. Fast speed."
io8_ft_fs_3v3  "General purpose IO. 5V tolerant. 3.3V range. Fast speed."
io8_ft_ms_1v2  "General purpose IO. 5V tolerant. 1.2V range. Medium speed."
io8_ft_ms_1v8  "General purpose IO. 5V tolerant. 1.8V range. Medium speed."
io8_ft_ms_3v3  "General purpose IO. 5V tolerant. 3.3V range. Medium speed."
io8_ft_ls_1v2  "General purpose IO. 5V tolerant. 1.2V range. Low speed."
io8_ft_ls_1v8  "General purpose IO. 5V tolerant. 1.8V range. Low speed."
io8_ft_ls_3v3  "General purpose IO. 5V tolerant. 3.3V range. Low speed."
io8_i2c_ft_1v2  "General purpose IO with I2C functionality. 5V tolerant. 1.2V range"
io8_i2c_ft_1v8  "General purpose IO with I2C functionality. 5V tolerant. 1.8V range"
io8_i2c_ft_3v3  "General purpose IO with I2C functionality. 5V tolerant. 3.3V range"
[Model Selector] io8usb_id_otg20_ft
io8_ft_hs_1v2  "General purpose IO. 5V tolerant. 1.2V range. High speed."
io8_ft_hs_1v8  "General purpose IO. 5V tolerant. 1.8V range. High speed."
io8_ft_hs_3v3  "General purpose IO. 5V tolerant. 3.3V range. High speed."
io8_ft_fs_1v2  "General purpose IO. 5V tolerant. 1.2V range. Fast speed."
io8_ft_fs_1v8  "General purpose IO. 5V tolerant. 1.8V range. Fast speed."
io8_ft_fs_3v3  "General purpose IO. 5V tolerant. 3.3V range. Fast speed."
io8_ft_ms_1v2  "General purpose IO. 5V tolerant. 1.2V range. Medium speed."
io8_ft_ms_1v8  "General purpose IO. 5V tolerant. 1.8V range. Medium speed."
io8_ft_ms_3v3  "General purpose IO. 5V tolerant. 3.3V range. Medium speed."
io8_ft_ls_1v2  "General purpose IO. 5V tolerant. 1.2V range. Low speed."
io8_ft_ls_1v8  "General purpose IO. 5V tolerant. 1.8V range. Low speed."
io8_ft_ls_3v3  "General purpose IO. 5V tolerant. 3.3V range. Low speed."
io8usb_id_ft_pup  "USB OTG ID PAD. 5V tolerant. With pull up"
io8usb_id_ft_nopup  "USB OTG ID PAD. 5V tolerant. No pull up"
[Model Selector] io8usb_lsfs_bcd_otg20_ft
io8_ft_hs_1v2  "General purpose IO. 5V tolerant. 1.2V range. High speed."
io8_ft_hs_1v8  "General purpose IO. 5V tolerant. 1.8V range. High speed."
io8_ft_hs_3v3  "General purpose IO. 5V tolerant. 3.3V range. High speed."
io8_ft_fs_1v2  "General purpose IO. 5V tolerant. 1.2V range. Fast speed."
io8_ft_fs_1v8  "General purpose IO. 5V tolerant. 1.8V range. Fast speed."
io8_ft_fs_3v3  "General purpose IO. 5V tolerant. 3.3V range. Fast speed."
io8_ft_ms_1v2  "General purpose IO. 5V tolerant. 1.2V range. Medium speed."
io8_ft_ms_1v8  "General purpose IO. 5V tolerant. 1.8V range. Medium speed."
io8_ft_ms_3v3  "General purpose IO. 5V tolerant. 3.3V range. Medium speed."
io8_ft_ls_1v2  "General purpose IO. 5V tolerant. 1.2V range. Low speed."
io8_ft_ls_1v8  "General purpose IO. 5V tolerant. 1.8V range. Low speed."
io8_ft_ls_3v3  "General purpose IO. 5V tolerant. 3.3V range. Low speed."
io8usb_fs_ft_pu2  ""USB full speed + pull up2""
io8usb_fs_ft_pu1  ""USB full speed + pull up1""
io8usb_fs_ft_pd  ""USB full speed + pull down""
io8usb_fs_ft  ""USB full speed""
io8usb_ls_ft_pu2  ""USB low speed + pull up2""
io8usb_ls_ft_pu1  ""USB low speed + pull up1""
io8usb_ls_ft_pd  ""USB low speed + pull down""
io8usb_ls_ft  ""USB low speed""
[Model Selector] io8usb_vbus_otg20_ft
io8_ft_hs_1v2  "General purpose IO. 5V tolerant. 1.2V range. High speed."
io8_ft_hs_1v8  "General purpose IO. 5V tolerant. 1.8V range. High speed."
io8_ft_hs_3v3  "General purpose IO. 5V tolerant. 3.3V range. High speed."
io8_ft_fs_1v2  "General purpose IO. 5V tolerant. 1.2V range. Fast speed."
io8_ft_fs_1v8  "General purpose IO. 5V tolerant. 1.8V range. Fast speed."
io8_ft_fs_3v3  "General purpose IO. 5V tolerant. 3.3V range. Fast speed."
io8_ft_ms_1v2  "General purpose IO. 5V tolerant. 1.2V range. Medium speed."
io8_ft_ms_1v8  "General purpose IO. 5V tolerant. 1.8V range. Medium speed."
io8_ft_ms_3v3  "General purpose IO. 5V tolerant. 3.3V range. Medium speed."
io8_ft_ls_1v2  "General purpose IO. 5V tolerant. 1.2V range. Low speed."
io8_ft_ls_1v8  "General purpose IO. 5V tolerant. 1.8V range. Low speed."
io8_ft_ls_3v3  "General purpose IO. 5V tolerant. 3.3V range. Low speed."
io8usb_adp  "USB Adp no pull up, no pull down"
io8usb_vbus  "USB Vbus"
[Model Selector] ioreset_ft
ioreset_ft_v33_pu_1v2  "Reset PAD - PU on. 5V tolerant. 1.2V range"
ioreset_ft_v33_pu_1v8  "Reset PAD - PU on. 5V tolerant. 1.8V range"
ioreset_ft_v33_pu_3v3  "Reset PAD - PU on. 5V tolerant. 3.3V range"
ioreset_ft_v33_1v2  "Reset PAD. 5V tolerant. 1.2V range"
ioreset_ft_v33_1v8  "Reset PAD. 5V tolerant. 1.8V range"
ioreset_ft_v33_3v3  "Reset PAD. 5V tolerant. 3.3V range"
[Model Selector] vpp_test_hv
vpp_1v2  "Vpp 1V2 range"
vpp_1v8  "Vpp 1v8 range"
vpp_3v3  "Vpp 3V3 range"
| Models and submodels in the file (50): io8_ft_hs_1v2 (I/O), io8_ft_hs_1v8 (I/O), io8_ft_hs_3v3 (I/O), io8_ft_fs_1v2 (I/O), io8_ft_fs_1v8 (I/O), io8_ft_fs_3v3 (I/O), io8_ft_ms_1v2 (I/O), io8_ft_ms_1v8 (I/O), io8_ft_ms_3v3 (I/O), io8_ft_ls_1v2 (I/O), io8_ft_ls_1v8 (I/O), io8_ft_ls_3v3 (I/O), io8_hslv_ft_hs_1v2 (I/O), io8_hslv_ft_hs_1v8 (I/O), io8_hslv_ft_hs_2v5 (I/O), io8_hslv_ft_fs_1v2 (I/O), io8_hslv_ft_fs_1v8 (I/O), io8_hslv_ft_fs_2v5 (I/O), io8_hslv_ft_ms_1v2 (I/O), io8_hslv_ft_ms_1v8 (I/O), io8_hslv_ft_ms_2v5 (I/O), io8_hslv_ft_ls_1v2 (I/O), io8_hslv_ft_ls_1v8 (I/O), io8_hslv_ft_ls_2v5 (I/O), io8_hslv_swpc_ft (I/O), io8_hslv_swpb_ft (I/O), io8_i2c_ft_1v2 (I/O), io8_i2c_ft_1v8 (I/O), io8_i2c_ft_3v3 (I/O), io8usb_id_ft_pup (Input), io8usb_id_ft_nopup (Input), io8usb_fs_ft_pu2 (I/O), io8usb_fs_ft_pu1 (I/O), io8usb_fs_ft_pd (I/O), io8usb_fs_ft (I/O), io8usb_ls_ft_pu2 (I/O), io8usb_ls_ft_pu1 (I/O), io8usb_ls_ft_pd (I/O), io8usb_ls_ft (I/O), io8usb_adp (I/O), io8usb_vbus (I/O), ioreset_ft_v33_pu_1v2 (I/O_open_drain), ioreset_ft_v33_pu_1v8 (I/O_open_drain), ioreset_ft_v33_pu_3v3 (I/O_open_drain), ioreset_ft_v33_1v2 (I/O_open_drain), ioreset_ft_v33_1v8 (I/O_open_drain), ioreset_ft_v33_3v3 (I/O_open_drain), vpp_1v2 (Input), vpp_1v8 (Input), vpp_3v3 (Input)
